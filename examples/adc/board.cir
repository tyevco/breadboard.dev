* Breadboard ADC example (ADR-003 Part C, plan step 9; on Breadboard's ADC
* model since ADR-005): an STM32F072 that reads back, through its ADC, an
* RC-filtered divider it drives itself.
*
*   U1.PA4 (DRIVE) -> 25 ohm (zout glue) -> R1 10k -> ADC_IN
*   ADC_IN -> R2 33k -> GND, C1 470 nF -> GND
*   ADC_IN -> U1.PA1 (adc_in: vref 3.3 V, 12 bits; ADC channel 1)
*   U1.PA5 (ALARM) -> R3 330 ohm -> LED -> D1 (red LED) -> GND
*   U1.PA6, U1.PA7: code bits 4 and 8 (not connected, probed)
*
* Firmware (examples/adc/firmware/adc.c, build/adc_board.elf, ADR-005 D7):
* TIM3 updates every 999 us on Renode (ARR ticks, ADR-003 Amendment 5 fact
* 5) and its TRGO triggers one conversion (EXTSEL = TRG3, EXTEN = rising;
* no TIM3 interrupt). The ADC (CKMODE = PCLK/2, SMP = 000, 12 bits) samples
* at T_k + 1063 ns and ends the conversion at T_k + 4750 ns (ADR-005 D4);
* the ADC interrupt then runs: analog watchdog 1 watches [1241, 2482] =
* [1.0 V, 2.0 V], an out-of-window conversion drives ALARM high and the next
* in-window one drives it low; code bits 4 and 8 go to PA6 and PA7; PA4
* toggles every 50 conversions. The CPU sleeps in wfi between interrupts.
*
* ADC_IN settles to 3.3 V * 33k / (25 + 10k + 33k) = 2.531087 V (code 3141,
* above the window) with tau = (10025 || 33000) ohm * 470 nF = 3.614 ms, and
* back to 0 V (code 0, below it): ALARM drops while ADC_IN crosses the
* window and rises again after.
*
* The binding graph is U1 -> ngspice (PA4, PA5) and ngspice -> U1 (PA1): a
* feedback loop. ngspice pushes ADC_IN at the lattice points where its
* 12-bit code changes (ADR-005 D5); the Renode engine writes the pushes of
* each grant to the ADC model as timed inputs, and a conversion reads the
* latest push strictly before its sample instant. The ADC pin is a sampled
* input (ADR-005 D3): with lookahead (the default) a quiet grant runs to the
* next TIM3 update whatever ADC_IN does, and an out-of-window value is
* reported at the end of the next conversion, as on silicon.
* `bb run --adc-model stock` with build/adc_board_isr.elf runs the ADR-003
* board on Renode's stock ADC instead.
*
* Directive grammar: see examples/spike/board.cir and cli/src/board.rs. U1
* and its pin models come from the package st/stm32f072rb (ADR-006; its
* pins.toml set `default`: digital_out 3.3 V, 5 ns, 25 ohm; adc_in vref
* 3.3 V, 12 bits, the channel from the pin's adc = { channel = "IN1" }),
* pinned in bb.lock with the platform stm32f072-bb@1.
*
*bb part U1 package=st/stm32f072rb
*bb pin U1.PA4 net=DRIVE model=digital_out
*bb pin U1.PA1 net=ADC_IN model=adc_in
*bb pin U1.PA5 net=ALARM model=digital_out
*bb pin U1.PA6 model=digital_out
*bb pin U1.PA7 model=digital_out

* Circuit body. Node 0 is GND.
R1 DRIVE ADC_IN 10k
R2 ADC_IN 0 33k
C1 ADC_IN 0 470n
R3 ALARM LED 330
D1 LED 0 LED_RED

* Red LED: the spike's model (examples/spike/board.cir).
.model LED_RED D(IS=1e-18 N=2 RS=2 CJO=10p)

* Solver tolerances, as in the spike.
.options RELTOL=1e-5 VNTOL=1e-8 ABSTOL=1e-13
.end
