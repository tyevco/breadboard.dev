* Breadboard ADC example, the loop opened (ADR-003 plan step 9, ADR-005): the
* same divider as examples/adc/board.cir, but driven by a circuit PULSE
* source with the ADR-003 firmware's PA4 timing (high from 49.95 ms for
* 49.95 ms, period 99.9 ms; on Breadboard's model the firmware toggles PA4
* 4.75 us later, at the end of the 50th conversion, but the loop is open, so
* the drive only has to resemble it, and the stock board keeps its ADR-003
* references), and every MCU output left unconnected. The binding graph is ngspice -> U1 (PA1)
* only, so grants are long (--max-quantum); the pushes of each grant reach
* the ADC model as timed inputs before Renode runs it (ADR-005 D5).
*
* Same firmware: examples/adc/firmware/build/adc_board.elf (with
* --adc-model stock: build/adc_board_isr.elf).
*
* U1 and its pin models come from the package st/stm32f072rb (ADR-006),
* pinned in bb.lock; see board.cir.
*
*bb part U1 package=st/stm32f072rb
*bb pin U1.PA1 net=ADC_IN model=adc_in
*bb pin U1.PA4 model=digital_out
*bb pin U1.PA5 model=digital_out
*bb pin U1.PA6 model=digital_out
*bb pin U1.PA7 model=digital_out

* Circuit body. Node 0 is GND.
VDRV DRV_INT 0 PULSE(0 3.3 49.95m 5n 5n 49.95m 99.9m)
RZ DRV_INT DRIVE 25
R1 DRIVE ADC_IN 10k
R2 ADC_IN 0 33k
C1 ADC_IN 0 470n

.options RELTOL=1e-5 VNTOL=1e-8 ABSTOL=1e-13
.end
