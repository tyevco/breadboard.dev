* Breadboard Phase 0 spike board: STM32F103 PA5 -> 330 ohm -> red LED -> GND.
*
* This file is a plain SPICE netlist (the circuit body) plus Breadboard
* directives. Directive lines start with "*bb", so ngspice sees them as
* comments. Grammar: "*bb <keyword> <name> key=value ...", whitespace
* separated, no quoting.
*
*   *bb part <ref> package=<id>
*       A part from a component package (ADR-006, packages/<id>): here
*       st/stm32f103c8, whose behavioural layer is Renode's STM32F103
*       platform (stm32f103-offline@1). `bb run --target <ref>` loads the
*       firmware into it. `bb open board.cir` pins the package's tree hash
*       and the platform's content hash in bb.lock (next to this file),
*       which `bb run` checks. (The Phase 0 form, `*bb part <ref>
*       engine=renode platform=stm32f103` with every pin parameter written
*       out, still works.)
*   *bb pin <ref>.<pin> net=<net> model=digital_out [set=<name>] [voh=.. ...]
*       Binds an MCU pin to a circuit net through its pin model
*       (spec/pin-model.md), with the parameters of the package's pins.toml
*       set `set` (default `default`: 3.3 V, 5 ns, 25 ohm for this MCU).
*       Explicit keys override it. The kernel generates the SPICE glue from
*       the model: an EXTERNAL voltage source driven by the pin's edges,
*       plus a series resistor of `zout` into <net>. Do not write that glue
*       here.
*
*bb part U1 package=st/stm32f103c8
*bb pin U1.PA5 net=PA5 model=digital_out

* Circuit body. Node 0 is GND.
R1 PA5 LED_A 330
D1 LED_A 0 LED_RED

* Red LED as an ngspice diode: Vf ~= 1.87 V at ~4 mA (Is, N fitted to a
* typical 5 mm red LED: 1.8-2.1 V at a few mA), 2 ohm series resistance,
* 10 pF junction capacitance.
.model LED_RED D(IS=1e-18 N=2 RS=2 CJO=10p)

* Solver tolerances (part of the board, so the step sequence is fixed by it).
* The ngspice default RELTOL=1e-3 leaves ~5 mV of Newton noise on the LED
* plateau; 1e-5 brings it well under the 1 mV golden tolerance.
.options RELTOL=1e-5 VNTOL=1e-8 ABSTOL=1e-13
.end
