* qod_usb5.0: test circuit of ti/tps22917 (view lsw). Generated by breadboard.dev scripts/dms_packages.py (make dms-vectors); do not edit.
* Source: dial-me-spinner@6854d25:hardware/sim/tests/test_load_switches.py (test_u2_qod_discharge[usb5.0]).
* ---- load_switches__nrf52840_gpio.lib
* =====================================================================================================
* load_switches__nrf52840_gpio.lib  --  nRF52840 (MDBT50Q-U1MV2) GPIO pad: push-pull output / disconnected input
* =====================================================================================================
* Part      : Nordic nRF52840 in the Raytac MDBT50Q-U1MV2 module (U10), pins P1.04 LED_PWR_EN, P1.02 OLED_VCC_EN,
*             P0.06 LED_DIN_MCU
* Datasheet : nRF52840 Product Specification v1.1, section 6.9.3.1 "GPIO Electrical Specification"
*             https://cdn.sparkfun.com/assets/d/2/6/2/6/nRF52840_PS_v1.1.pdf
*             (also https://docs.nordicsemi.com/bundle/ps_nrf52840/page/pin.html)
* Modelled:
*   Output high/low as a Thevenin source: the pad drives VDD (or GND) through rout.  The PS gives the current at
*   VDD - 0.4 V (high) / VSS + 0.4 V (low), so rout = 0.4 V / I:
*     standard drive  IOH,SD / IOL,SD = 1 / 2 / 4 mA (min/typ/max)  -> rout 400 / 200 / 100 Ohm
*     high drive      IOH,HDH        = 6 / 9 / 14 mA (VDD >= 2.7 V) -> rout  67 /  44 /  29 Ohm
*     (IOL,HDH 6/10/15 mA -> 67/40/27 Ohm; the high-side numbers are used for both edges)
*   Disconnected input (reset, before firmware configures the pin, or pinctrl sleep with the input buffer off):
*     CPAD = 3 pF (PS "Pad capacitance"), plus a leakage current ileak (A, + = sourced INTO the pad node).
*     The PS gives NO pad leakage figure; ileak is a test ASSUMPTION and must be stated by the test.
*   Control: node OUT (0 / 1 V logic) selects the level, node OE (0 / 1 V) enables the driver.
*   Pad clamps to VDD and GND: implied by the absolute maximum VI/O = -0.3 V .. VDD + 0.3 V (PS v1.1 chapter 9 Absolute
*     maximum ratings); the PS gives no I-V, so they are generic silicon junctions (IS 1e-14, N 1, RS 10 Ohm,
*     ASSUMPTION).  They only matter for a released pad whose node would otherwise float.
* NOT modelled: VOH/VOL non-linearity beyond the 0.4 V point (the Thevenin line is optimistic at large currents
*   for 'min' drive and pessimistic for 'max'), edge rate control, the internal 13 kOhm pull resistors (not used
*   on these pins), input threshold (VIH 0.7 VDD / VIL 0.3 VDD are limits in the tests).
* =====================================================================================================

.subckt LSW_NRF_GPIO PAD VDD gnd_port OUT OE params: rout=200 cpad=3p ileak=0
B_DRV    NDRV gnd_port V = V(OUT,gnd_port) > 0.5 ? V(VDD,gnd_port) : 0
a_OE     %vd(OE gnd_port) %gd(NDRV PAD) lsw_nrf_oe
.model lsw_nrf_oe aswitch(cntl_off=0.2 cntl_on=0.8 r_off=1e12 r_on={rout} log=TRUE limit=TRUE)
C_PAD    PAD gnd_port {cpad}
I_LEAK   gnd_port PAD DC {ileak}
D_CLH    PAD VDD lsw_nrf_esd
D_CLL    gnd_port PAD lsw_nrf_esd
.model lsw_nrf_esd d (is=1e-14 n=1.0 rs=10)
.ends LSW_NRF_GPIO
* ---- load_switches__ws2812c.lib
* =====================================================================================================
* load_switches__ws2812c.lib  --  Worldsemi WS2812C-2020-V6, supply and DIN port only (D101..D148 on VLED)
* =====================================================================================================
* Part      : Worldsemi WS2812C-2020-V6 (SMD2020-4P: 1 DO, 2 GND, 3 DI, 4 VDD), LCSC C55109522
* Datasheet : https://datasheet.lcsc.com/datasheet/pdf/8c7f104c99e52e4adb687ae84e594e95.pdf
*             (Worldsemi WS2812C-2020-V6 datasheet, Chinese, 9 pages; no revision code printed; the URL in
*             hardware/design/sheets/leds.py LED_DS)
* Modelled (values and where they come from):
*   VDD static current  <= 1 uA per pixel ("静态功耗低于1μA", features, p.1; LED table "静态电流 ≦1μA" @5 V, p.3)
*                         -> 1 uA at VDD >= 3.3 V, scaled linearly below (CMOS bias, assumption for VDD < 3.3 V).
*   LED channel current  5 mA per channel ("每个通道工作电流5mA", p.1; IV test condition 5 mA, p.3), 3 channels,
*                         as a constant-current load "duty" (0..1 of full white); it fades linearly to zero
*                         between VDD = 2 V and 1 V (ASSUMPTION, only so a DC operating point exists from 0 V;
*                         the DC load-extreme runs sit at VDD >= 3.4 V where the full current flows).
*   DI input            : CI <= 15 pF (switching table "输入电容 CI 15 pF max", p.3) -> 15 pF to VSS;
*                         II <= +-1 uA at VI = VDD/VSS (p.3) -> not modelled (negligible vs 100 kOhm R41);
*                         clamp diodes DI->VDD and VSS->DI, implied by the absolute maximum VI = -0.3 V .. VDD + 0.7 V
*                         (最大额定值, p.2).  The datasheet gives NO clamp I-V; the diode below is a generic
*                         silicon junction ASSUMPTION (IS 1e-14 A, N 1.0, RS 10 Ohm: about 0.70 V at 5 mA,
*                         0.64 V at 0.5 mA).  Override with params is/n/rs for a sensitivity bracket.
*   Supply range 3.3-5.3 V (p.2) and VIH 0.55 VDD / VIL 0.7 V (p.3) are LIMITS used by the tests, not modelled.
* NOT modelled: the data protocol / DOUT driver (DOUT left open here), PWM ripple of the LED current,
*   power-on-reset threshold (not given), behaviour at VDD below 3.3 V other than the bias scaling above,
*   LED forward-voltage drop-out (the "VF 恒流曲线" figure has no readable numbers), temperature.
* =====================================================================================================

* One pixel: DIN, VDD, VSS.  duty = fraction of full white (3 x 5 mA) drawn as LED current.
.subckt LSW_WS2812C DIN VDD VSS params: duty=0 is=1e-14 n=1.0 rs=10
B_IQ     VDD VSS I = 1u * min(1, max(0, V(VDD,VSS)/3.3))
B_LED    VDD VSS I = {duty} * 15m * min(1, max(0, (V(VDD,VSS) - 1.0)/1.0))
D_CLH    DIN VDD lsw_ws_esd
D_CLL    VSS DIN lsw_ws_esd
C_IN     DIN VSS 15p
.model lsw_ws_esd d (is={is} n={n} rs={rs} cjo=1p)
.ends LSW_WS2812C
* ---- load_switches__bq25180.lib
* =====================================================================================================
* load_switches__bq25180.lib  --  TI BQ25180 power path, as the VSYS source seen by the main-board load switches
* =====================================================================================================
* Part      : Texas Instruments BQ25180YBGR (base board U1, DSBGA-8)
* Datasheet : https://www.ti.com/lit/ds/symlink/bq25180.pdf  SLUSE99C (Sept 2021, revised Jan 2023)
* Register settings used (docs/architecture.md 6.5, docs/firmware.md 13.1): SYS 4.5 V on USB by default (the POR
*   default and the highest value firmware allows; firmware writes SYS_REG 0x20 = 4.4 V, param vsysreg), TMR_ILIM
*   ILIM code 500 mA (475 mA typ) or 100 mA (0xC9, param ilim), CHARGECTRL1 BATOCP 1.5 A, BUVLO 3.0 V.
* Two sub-circuits, chosen by the test:
*   LSW_BQ25180_BAT  battery only (no VBUS): cell source vbat (the battery terminal voltage before the event)
*                    -> rpack (cell + PCM + leads, NOT a BQ25180 parameter; given by the test)
*                    -> BATFET RON_BAT (Table 7.5: 55 mOhm typ, 90 mOhm max) -> SYS.  Fully on, linear.
*   LSW_BQ25180_USB  VBUS present: input FET from IN to SYS regulated to min(VSYS_REG, VBUS) with output
*                    resistance RON_IN (Table 7.5: 270 mOhm typ, 470 mOhm max; also used in regulation, which
*                    makes the modelled droop pessimistic) and current limit ILIM (500 mA code: 450 / 475 /
*                    498 mA min/typ/max) through the XSPICE "ilimit" block.  The block may also SINK (through
*                    RON_IN): physically SYS never rises above the regulation target in these scenarios, but a
*                    source-only block lets Newton park SYS at absurd voltages, so sinking is allowed.
*                    VSYS_REG accuracy +-2 % (Table 7.5 VSYS_REG_ACCURACY) -> param vsysreg.
*                    Battery supplement (Table 7.5 VBSUP1 = 40 mV: battery feeds SYS when VSYS < VBAT - 40 mV):
*                    diode with ~40 mV at ~10 mA (IS 3.4e-16, N 0.05) in series with RON_BAT and rpack.
* NOT modelled: BATOCP / BUVLO / ILIM-interrupt / thermal trips (the tests compare currents and voltages against
*   those thresholds instead), the BUVLO gate on supplement mode (SLUSE99C 8.3.3: no supplement while VBAT <
*   VBUVLO; the D_SUP diode always conducts, so a test models a cell below BUVLO with vbat=0), input UVLO/OVP, VINDPM, regulation-loop dynamics, the charge current (assumed to
*   give way instantly to the system load, DPPM), the 25 Ohm SYS pull-down (ship/shutdown only).
* Pins: SYS GND.
* =====================================================================================================

.subckt LSW_BQ25180_BAT SYS gnd_port params: vbat=3.7 rpack=0.25 ronbat=55m
V_BAT    VCELL gnd_port {vbat}
R_PACK   VCELL BAT {rpack}
R_BATFET BAT SYS {ronbat}
.ends LSW_BQ25180_BAT

.subckt LSW_BQ25180_USB SYS gnd_port params: vbus=5.0 vsysreg=4.5 ronin=0.27 ilim=0.475 vbat=3.7 rpack=0.25 ronbat=55m
V_BUS    VBUS gnd_port {vbus}
V_REF    VREG gnd_port {min(vsysreg, vbus)}
a_INFET  VREG VBUS gnd_port SYS lsw_bq_infet
.model lsw_bq_infet ilimit(in_offset=0 gain=1 r_out_source={ronin} r_out_sink={ronin} i_limit_source={ilim}
+        i_limit_sink=10 v_pwr_range=0.01 i_source_range=1e-2 i_sink_range=1e-2 r_out_domain=1e-3)
V_BAT    VCELL gnd_port {vbat}
R_PACK   VCELL BAT {rpack}
D_SUP    BAT BSUP lsw_bq_sup
.model lsw_bq_sup d (is=3.4e-16 n=0.05 xti=0 eg=0)
R_BATFET BSUP SYS {ronbat}
.ends LSW_BQ25180_USB
XBQ n_vsys_b 0 LSW_BQ25180_USB params: vbus=5.0 vbat=3.7 rpack=0.25 ronbat=55m ronin=0.27 vsysreg=4.5 ilim=0.475
Cb_C2 n_vsys_b 0 1e-05
Cb_C4 n_vsys_b 0 1e-05
RHARN n_vsys_b n_vsys 0.0142
.nodeset v(n_vsys)=4.5 v(n_vsys_b)=4.5 v(n_p3v3)=3.3
CC1 n_vsys 0 2.2e-05
CC2 n_vsys 0 1e-05
CC5 n_vsys_sense 0 1e-07
CC6 n_vsys 0 1e-05
CC41 n_vsys 0 1e-05
CC70 n_vsys 0 1e-07
CC72 n_vsys 0 1e-07
CC74 n_vsys 0 1e-05
RR1 n_vsys n_vsys_sense 2.2e+06
RR2 n_vsys_sense 0 1e+06
I3V3 n_vsys 0 DC 0.05
BIBAT n_ibat 0 V = (V(xbq.vcell) - V(xbq.bat))/0.25
B3V3 n_p3v3 0 V = min(3.3, V(n_vsys) - 0.0441667)
CC7 n_lsw_ct n_vsys 1e-09
CC8 n_vled 0 2.2e-05
CC9 n_vled 0 2.2e-05
CC101 n_vled 0 1e-07
CC102 n_vled 0 1e-07
CC103 n_vled 0 1e-07
CC104 n_vled 0 1e-07
CC105 n_vled 0 1e-07
CC106 n_vled 0 1e-07
CC107 n_vled 0 1e-07
CC108 n_vled 0 1e-07
CC109 n_vled 0 1e-07
CC110 n_vled 0 1e-07
CC111 n_vled 0 1e-07
CC112 n_vled 0 1e-07
CC113 n_vled 0 1e-07
CC114 n_vled 0 1e-07
CC115 n_vled 0 1e-07
CC116 n_vled 0 1e-07
CC117 n_vled 0 1e-07
CC118 n_vled 0 1e-07
CC119 n_vled 0 1e-07
CC120 n_vled 0 1e-07
CC121 n_vled 0 1e-07
CC122 n_vled 0 1e-07
CC123 n_vled 0 1e-07
CC124 n_vled 0 1e-07
CC125 n_vled 0 1e-07
CC126 n_vled 0 1e-07
CC127 n_vled 0 1e-07
CC128 n_vled 0 1e-07
CC129 n_vled 0 1e-07
CC130 n_vled 0 1e-07
CC131 n_vled 0 1e-07
CC132 n_vled 0 1e-07
CC133 n_vled 0 1e-07
CC134 n_vled 0 1e-07
CC135 n_vled 0 1e-07
CC136 n_vled 0 1e-07
CC137 n_vled 0 1e-07
CC138 n_vled 0 1e-07
CC139 n_vled 0 1e-07
CC140 n_vled 0 1e-07
CC141 n_vled 0 1e-07
CC142 n_vled 0 1e-07
CC143 n_vled 0 1e-07
CC144 n_vled 0 1e-07
CC145 n_vled 0 1e-07
CC146 n_vled 0 1e-07
CC147 n_vled 0 1e-07
CC148 n_vled 0 1e-07
RR3 n_led_pwr_en 0 100000
RR4 n_vled n_lsw_qod 68
XD101 n_led_din n_vled 0 LSW_WS2812C params: duty=0
XD102 n_led_d1 n_vled 0 LSW_WS2812C params: duty=0
XD103 n_led_d2 n_vled 0 LSW_WS2812C params: duty=0
XD104 n_led_d3 n_vled 0 LSW_WS2812C params: duty=0
XD105 n_led_d4 n_vled 0 LSW_WS2812C params: duty=0
XD106 n_led_d5 n_vled 0 LSW_WS2812C params: duty=0
XD107 n_led_d6 n_vled 0 LSW_WS2812C params: duty=0
XD108 n_led_d7 n_vled 0 LSW_WS2812C params: duty=0
XD109 n_led_d8 n_vled 0 LSW_WS2812C params: duty=0
XD110 n_led_d9 n_vled 0 LSW_WS2812C params: duty=0
XD111 n_led_d10 n_vled 0 LSW_WS2812C params: duty=0
XD112 n_led_d11 n_vled 0 LSW_WS2812C params: duty=0
XD113 n_led_d12 n_vled 0 LSW_WS2812C params: duty=0
XD114 n_led_d13 n_vled 0 LSW_WS2812C params: duty=0
XD115 n_led_d14 n_vled 0 LSW_WS2812C params: duty=0
XD116 n_led_d15 n_vled 0 LSW_WS2812C params: duty=0
XD117 n_led_d16 n_vled 0 LSW_WS2812C params: duty=0
XD118 n_led_d17 n_vled 0 LSW_WS2812C params: duty=0
XD119 n_led_d18 n_vled 0 LSW_WS2812C params: duty=0
XD120 n_led_d19 n_vled 0 LSW_WS2812C params: duty=0
XD121 n_led_d20 n_vled 0 LSW_WS2812C params: duty=0
XD122 n_led_d21 n_vled 0 LSW_WS2812C params: duty=0
XD123 n_led_d22 n_vled 0 LSW_WS2812C params: duty=0
XD124 n_led_d23 n_vled 0 LSW_WS2812C params: duty=0
XD125 n_led_d24 n_vled 0 LSW_WS2812C params: duty=0
XD126 n_led_d25 n_vled 0 LSW_WS2812C params: duty=0
XD127 n_led_d26 n_vled 0 LSW_WS2812C params: duty=0
XD128 n_led_d27 n_vled 0 LSW_WS2812C params: duty=0
XD129 n_led_d28 n_vled 0 LSW_WS2812C params: duty=0
XD130 n_led_d29 n_vled 0 LSW_WS2812C params: duty=0
XD131 n_led_d30 n_vled 0 LSW_WS2812C params: duty=0
XD132 n_led_d31 n_vled 0 LSW_WS2812C params: duty=0
XD133 n_led_d32 n_vled 0 LSW_WS2812C params: duty=0
XD134 n_led_d33 n_vled 0 LSW_WS2812C params: duty=0
XD135 n_led_d34 n_vled 0 LSW_WS2812C params: duty=0
XD136 n_led_d35 n_vled 0 LSW_WS2812C params: duty=0
XD137 n_led_d36 n_vled 0 LSW_WS2812C params: duty=0
XD138 n_led_d37 n_vled 0 LSW_WS2812C params: duty=0
XD139 n_led_d38 n_vled 0 LSW_WS2812C params: duty=0
XD140 n_led_d39 n_vled 0 LSW_WS2812C params: duty=0
XD141 n_led_d40 n_vled 0 LSW_WS2812C params: duty=0
XD142 n_led_d41 n_vled 0 LSW_WS2812C params: duty=0
XD143 n_led_d42 n_vled 0 LSW_WS2812C params: duty=0
XD144 n_led_d43 n_vled 0 LSW_WS2812C params: duty=0
XD145 n_led_d44 n_vled 0 LSW_WS2812C params: duty=0
XD146 n_led_d45 n_vled 0 LSW_WS2812C params: duty=0
XD147 n_led_d46 n_vled 0 LSW_WS2812C params: duty=0
XD148 n_led_d47 n_vled 0 LSW_WS2812C params: duty=0
VOE n_oe_led 0 1
XIO_LED_PWR_EN n_led_pwr_en n_p3v3 0 n_ctl_led n_oe_led LSW_NRF_GPIO params: rout=44.4444 ileak=0
