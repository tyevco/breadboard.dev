* qod_open_3.6: test circuit of ti/tps22917 (view lsw). Generated by breadboard.dev scripts/dms_packages.py (make dms-vectors); do not edit.
* Source: dial-me-spinner@6854d25:hardware/sim/tests/test_load_switches.py (test_model_ron_qod_and_on_threshold[3.6], switch A with QOD floating).
* RON at 200 mA with QOD left floating (the ron_3.6 circuit, QOD pin on its own node qf):
* ON high, RL = VIN / 0.2 A
VIN vin 0 3.6
VONC onc 0 3.3
RLC vc 0 18
