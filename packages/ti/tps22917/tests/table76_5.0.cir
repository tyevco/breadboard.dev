* table76_5.0: test circuit of ti/tps22917 (view lsw). Generated by breadboard.dev scripts/dms_packages.py (make dms-vectors); do not edit.
* Source: dial-me-spinner@6854d25:hardware/sim/tests/test_load_switches.py (test_model_turn_on_matches_table_7_6[5.0]).
VIN vin 0 5.0
CT1 ct vin 1000p
CL vout 0 1u
RL vout 0 10
