* ron_5.0: test circuit of ti/tps22917 (view lsw). Generated by breadboard.dev scripts/dms_packages.py (make dms-vectors); do not edit.
* Source: dial-me-spinner@6854d25:hardware/sim/tests/test_load_switches.py (test_model_ron_qod_and_on_threshold[5.0]).
* RON at 200 mA (switch A of the suite's test_model_ron_qod_and_on_threshold[5.0]): ON high, QOD on VOUT, RL = VIN / 0.2 A
VIN vin 0 5.0
VONA ona 0 3.3
RLA va 0 25
