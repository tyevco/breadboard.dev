* qod_dc_5.0: test circuit of ti/tps22917 (view lsw). Generated by breadboard.dev scripts/dms_packages.py (make dms-vectors); do not edit.
* Source: dial-me-spinner@6854d25:hardware/sim/tests/test_load_switches.py (test_model_ron_qod_and_on_threshold[5.0]).
* QOD in the off state (switch B of the suite's test_model_ron_qod_and_on_threshold[5.0]): ON low, VOUT held at 1 V, QOD to VOUT
* through 1 Ohm, so V(qb) = QOD/(QOD + 1 Ohm)
VIN vin 0 5.0
VONB onb 0 0
VF vb 0 1
RQ qb vb 1
