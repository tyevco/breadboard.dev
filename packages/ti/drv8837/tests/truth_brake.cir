* truth_brake: test circuit of ti/drv8837 (view bridge): the suite's test_drv8837_model_matches_datasheet
* deck, state brake (dial-me-spinner@6854d25:hardware/sim/tests/test_motor_drive.py): VM 5 V, VCC 3 V,
* nSLEEP 3 V, IN1 3 V, IN2 3 V; each OUT through 1 kOhm to a 2.5 V bias, which shows Z as 2.5 V.
VVM vm 0 5
VCC vcc 0 3
VN ns 0 3
V1 in1 0 3
V2 in2 0 3
Ro1 o1 vh 1k
Ro2 o2 vh 1k
Vh vh 0 2.5
